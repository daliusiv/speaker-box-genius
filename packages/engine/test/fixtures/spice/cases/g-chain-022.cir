* g-chain-022: chain (sealed), purifi/ptt4-0m04-nac-04 (Qts 0.28), 9.367 L, 1 EQ, passive parts
* Speaker Box Genius SPICE validation netlist. SI units; acoustic side: Pa, m^3/s. See packages/engine/validation/spice/elements.ts.
V1 src 0 AC 26.0768096208106
A1 %vd(src 0) %vd(amp 0) xf1
Vrg amp spk 0
Vin spk n0 0
Lx1 n0 n1 0.006753
Lx2 n1 0 0.005299
Rx3 n1 n3 1.789
Cx4 n3 0 0.000863
Rbl_x4c n3 0 1e+15
Vx9 n3 bk 0
Re1 bk c1a 3.4
Le1 c1a c1b 0.00026
Hemf1 c1b c1d Vcone1 936.90784350152
Vi1 c1d w1 0
Re2 w1 c2a 3.4
Le2 c2a c2b 0.00026
Hemf2 c2b c2d Vcone2 936.90784350152
Vi2 c2d 0 0
Hd1 u1h1 0 Vi1 936.90784350152
Ras11 u1h1 u1r1 18441.0988910645
Lmas11 u1r1 u1m1 256.811803898946
Ccas11 u1m1 u1k1 4.28097613801685e-8
Rbl_u1k1 u1k1 0 1e+15
Vcone1 u1k1 box 0
Hd2 u2h1 0 Vi2 936.90784350152
Ras21 u2h1 u2r1 18441.0988910645
Lmas21 u2r1 u2m1 256.811803898946
Ccas21 u2m1 u2k1 4.28097613801685e-8
Rbl_u2k1 u2k1 0 1e+15
Vcone2 u2k1 box 0
Rbl_box box 0 1e+15
Cab box 0 8.01998069696076e-8
Fpc1 0 prs Vcone1 -1
Fpc2 0 prs Vcone2 -1
Lrad prs 0 0.154384363389331
Fx 0 xn Vcone1 176.36684303351
Cx xn 0 1
Rbl_xn xn 0 1e+15
* probes: V(spk) V(prs) V(xn) V(box) I(Vin) I(Vcone1)
.model xf1 s_xfer(num_coeff=[1.14643648789878 186.828556490546 324565.898782114] den_coeff=[1.14643648789878 162.964593732506 246946.507142311])
.ac dec 50 5 2000
.end
