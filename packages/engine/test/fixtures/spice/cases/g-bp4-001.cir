* g-bp4-001: bp4, bc-speakers/15sw115-8ohm (Qts 0.24), 58.53 L, rear 19.56 L closed, front 38.97 L 4 × purifi/ptt10-0pr-na2-01 at 33.7 Hz
* Speaker Box Genius SPICE validation netlist. SI units; acoustic side: Pa, m^3/s. See packages/engine/validation/spice/elements.ts.
V1 amp 0 AC 3.24037034920393
Rg amp spk 0.1
Vin spk bk 0
Re1 bk c1a 5.2
Le1 c1a c1b 0.0018
Hemf1 c1b c1d Vcone1 349.247810880237
Vi1 c1d w1 0
Re2 w1 c2a 5.2
Le2 c2a c2b 0.0018
Hemf2 c2b c2d Vcone2 349.247810880237
Vi2 c2d 0 0
Hd1 u1h1 br Vi1 349.247810880237
Ras11 u1h1 u1r1 1332.75823213109
Lmas11 u1r1 u1m1 26.6658933313242
Ccas11 u1m1 u1k1 7.75439709562585e-7
Rbl_u1k1 u1k1 0 1e+15
Vcone1 u1k1 bf 0
Hd2 u2h1 br Vi2 349.247810880237
Ras21 u2h1 u2r1 1332.75823213109
Lmas21 u2r1 u2m1 26.6658933313242
Ccas21 u2m1 u2k1 7.75439709562585e-7
Rbl_u2k1 u2k1 0 1e+15
Vcone2 u2k1 bf 0
Rbl_bf bf 0 1e+15
Cabf bf 0 2.74717140742309e-7
Rpr1 bf r1 519.712614518147
Lpr1 r1 q1 90.7407407407407
Cpr1 q1 s1 0.00000228096
Vpr1 s1 0 0
Fxp1 0 xp1 Vpr1 6.94444444444444
Cxp1 xp1 0 1
Rbl_xp1 xp1 0 1e+15
Rbl_br br 0 1e+15
Rabr br rb1 99.1931204515399
Cabr rb1 0 1.37887279264038e-7
Rbl_rb1 rb1 0 1e+15
Ralr br rl1 131926.850200548
Vleakr rl1 0 0
Ricl br bf 586413.622137681
Fpo1 0 prs Vpr1 1
Fpo2 0 prs Vleakr 1
Lrad prs 0 0.0477843688524725
Fx 0 xn Vcone1 11.6959064327485
Cx xn 0 1
Rbl_xn xn 0 1e+15
* probes: V(spk) V(prs) V(xn) V(br) V(bf) V(xp1) I(Vin) I(Vcone1) I(Vpr1)
.ac dec 50 5 2000
.end
