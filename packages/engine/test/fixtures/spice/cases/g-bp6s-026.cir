* g-bp6s-026: bp6s, dayton-audio/rss390ho-4 (Qts 0.32), 57.19 L, rear 35.81 L port at 21.0 Hz, front 21.38 L 1 × dayton-audio/rss390-pr at 38.5 Hz
* Speaker Box Genius SPICE validation netlist. SI units; acoustic side: Pa, m^3/s. See packages/engine/validation/spice/elements.ts.
V1 amp 0 AC 1.78885438199983
Vrg amp spk 0
Vin spk bk 0
Re1 bk c1a 3.2
Le1 c1a c1b 0.00179
Hemf1 c1b c1d Vcone1 216.915587087206
Vi1 c1d 0 0
Hd1 u1h1 br Vi1 216.915587087206
Ras11 u1h1 u1r1 1394.67565823895
Lmas11 u1r1 u1m1 38.0961649915766
Ccas11 u1m1 u1k1 0.00000143840798237366
Rbl_u1k1 u1k1 0 1e+15
Vcone1 u1k1 bf 0
Rbl_bf bf 0 1e+15
Rabf bf fb1 226.097839698693
Cabf fb1 0 1.830545396616e-7
Rbl_fb1 fb1 0 1e+15
Ralf bf fl1 226097.839698693
Vleakf fl1 0 0
Rpr1 bf r1 1522.25272185762
Lpr1 r1 q1 104.89132102562
Cpr1 q1 s1 0.000001514119552
Vpr1 s1 0 0
Fxp1 0 xp1 Vpr1 12.0540019286403
Cxp1 xp1 0 1
Rbl_xp1 xp1 0 1e+15
Rbl_br br 0 1e+15
Rabr br rb1 224.517418090277
Cabr rb1 0 3.06603511004767e-7
Rbl_rb1 rb1 0 1e+15
Ralr br rl1 222272.243909374
Vleakr rl1 0 0
Rapr br rp1 212.904448189056
Lmapr rp1 rp2 187.009027870265
Vportr rp2 bf 0
Fvr 0 vr Vportr 130.409226821252
Rvr vr 0 1
Ricl br bf 185268.714440462
Fpo1 0 prs Vleakf 1
Fpo2 0 prs Vpr1 1
Fpo3 0 prs Vleakr 1
Lrad prs 0 0.154384363389331
Fx 0 xn Vcone1 12.0540019286403
Cx xn 0 1
Rbl_xn xn 0 1e+15
* probes: V(spk) V(prs) V(xn) V(vr) V(br) V(bf) V(xp1) I(Vin) I(Vcone1) I(Vpr1)
.ac dec 50 5 2000
.end
