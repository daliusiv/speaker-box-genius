* g-chain-059: chain (sealed), bc-speakers/15pl100 (Qts 0.20), 109.4 L, HP butterworth 2, 3 EQ, passive parts
* Speaker Box Genius SPICE validation netlist. SI units; acoustic side: Pa, m^3/s. See packages/engine/validation/spice/elements.ts.
V1 src 0 AC 1.58113883008419
A1 %vd(src 0) %vd(f1 0) xf1
A2 %vd(f1 0) %vd(f2 0) xf2
A3 %vd(f2 0) %vd(f3 0) xf3
A4 %vd(f3 0) %vd(amp 0) xf4
Rg amp spk 0.1
Vin spk n0 0
Vx1 n0 n1 0
Cx3 n1 n3 0.0005074
Rbl_x3 n1 n3 1e+15
Vx9 n3 bk 0
Re1 bk c1a 5
Le1 c1a c1b 0.0017
Hemf1 c1b c1d Vcone1 307.147172867968
Vi1 c1d 0 0
Re2 bk c2a 5
Le2 c2a c2b 0.0017
Hemf2 c2b c2d Vcone2 307.147172867968
Vi2 c2d 0 0
Hd1 u1h1 0 Vi1 307.147172867968
Ras11 u1h1 u1r1 600.341546004997
Lmas11 u1r1 u1m1 17.0435768187792
Ccas11 u1m1 u1k1 0.00000108561559338762
Rbl_u1k1 u1k1 0 1e+15
Vcone1 u1k1 box 0
Hd2 u2h1 0 Vi2 307.147172867968
Ras21 u2h1 u2r1 600.341546004997
Lmas21 u2r1 u2m1 17.0435768187792
Ccas21 u2m1 u2k1 0.00000108561559338762
Rbl_u2k1 u2k1 0 1e+15
Vcone2 u2k1 box 0
Rbl_box box 0 1e+15
Rab box b1 33.9449402993589
Cab b1 0 7.71210038419516e-7
Rbl_b1 b1 0 1e+15
Ral box l1 59964.948777223
Vleak l1 0 0
Fpc1 0 prs Vcone1 -1
Fpc2 0 prs Vcone2 -1
Fpl 0 prs Vleak 1
Lrad prs 0 0.19113747540989
Fx 0 xn Vcone1 11.6959064327485
Cx xn 0 1
Rbl_xn xn 0 1e+15
* probes: V(spk) V(prs) V(xn) V(box) I(Vin) I(Vcone1) I(Vleak)
.model xf1 s_xfer(num_coeff=[1 0 0] den_coeff=[1 234.761934452288 27556.5829338902])
.model xf2 s_xfer(num_coeff=[1.07006460759938 340.653638502113 915183.828425865] den_coeff=[1 329.312360522285 915183.828425865])
.model xf3 s_xfer(num_coeff=[1 679.495031162965 1348229.01874311] den_coeff=[1 318.739792283923 1348229.01874311])
.model xf4 s_xfer(num_coeff=[1 418.051003810251 129257.408265487] den_coeff=[1 349.132561502621 48057.5554386373])
.ac dec 50 5 2000
.end
