* g-chain-006: chain (sealed), redcatt/81find (Qts 0.50), 8.921 L, passive parts
* Speaker Box Genius SPICE validation netlist. SI units; acoustic side: Pa, m^3/s. See packages/engine/validation/spice/elements.ts.
V1 amp 0 AC 21.6794833886788
Rg amp spk 0.5
Vin spk n0 0
Vx1 n0 n1 0
Rx2 n1 x2n1 1.785
Cx2 x2n1 0 0.0006616
Rbl_x2c x2n1 0 1e+15
Rx3 n1 x3n1 6.093
Cx3 x3n1 n3 0.0005524
Rbl_x3c x3n1 n3 1e+15
Vx9 n3 bk 0
Re1 bk c1a 4.7
Le1 c1a c1b 0.00044
Hemf1 c1b c1d Vcone1 470.607851759151
Vi1 c1d 0 0
Hd1 u1h1 0 Vi1 470.607851759151
Ras11 u1h1 u1r1 2990.95496427067
Lmas11 u1r1 u1m1 49.685137256581
Ccas11 u1m1 u1k1 7.96588065277928e-8
Rbl_u1k1 u1k1 0 1e+15
Vcone1 u1k1 box 0
Rbl_box box 0 1e+15
Rab box b1 376.002639954644
Cab b1 0 6.28881604455256e-8
Rbl_b1 b1 0 1e+15
Ral box l1 210119.669229389
Vleak l1 0 0
Fpc1 0 prs Vcone1 -1
Fpl 0 prs Vleak 1
Lrad prs 0 0.19113747540989
Fx 0 xn Vcone1 46.7726847521048
Cx xn 0 1
Rbl_xn xn 0 1e+15
* probes: V(spk) V(prs) V(xn) V(box) I(Vin) I(Vcone1) I(Vleak)
.ac dec 50 5 2000
.end
