* g-chain-040: chain (vented), 18-sound/12nmb1000 (Qts 0.19), 29.5 L, Fb 39.3 Hz, HP linkwitz-riley 2, passive parts
* Speaker Box Genius SPICE validation netlist. SI units; acoustic side: Pa, m^3/s. See packages/engine/validation/spice/elements.ts.
V1 src 0 AC 2.83
A1 %vd(src 0) %vd(f1 0) xf1
A2 %vd(f1 0) %vd(amp 0) xf2
Rg amp spk 0.1
Vin spk n0 0
Rx1 n0 x1n1 7.334
Lx1 x1n1 x1n2 0.006942
Cx1 x1n2 n1 0.0001137
Rbl_x1c x1n2 n1 1e+15
Rx3 n1 x3n1 10.67
Lx3 x3n1 n3 0.0003028
Vx9 n3 bk 0
Re1 bk c1a 5.953915
Le1 c1a c1b 0.00069
Hemf1 c1b c1d Vcone1 456.734960867795
Vi1 c1d 0 0
Re2 bk c2a 5.953915
Le2 c2a c2b 0.00069
Hemf2 c2b c2d Vcone2 456.734960867795
Vi2 c2d 0 0
Hd1 u1h1 0 Vi1 456.734960867795
Ras11 u1h1 u1r1 857.90685391758
Lmas11 u1r1 u1m1 21.2395736798621
Ccas11 u1m1 u1k1 4.08984593404824e-7
Rbl_u1k1 u1k1 0 1e+15
Vcone1 u1k1 box 0
Hd2 u2h1 0 Vi2 456.734960867795
Ras21 u2h1 u2r1 857.90685391758
Lmas21 u2r1 u2m1 21.2395736798621
Ccas21 u2m1 u2k1 4.08984593404824e-7
Rbl_u2k1 u2k1 0 1e+15
Vcone2 u2k1 box 0
Rbl_box box 0 1e+15
Vrap box p1 0
Lmap p1 p2 78.6907201087003
Vport p2 0 0
Fvp 0 vn Vport 78.4767228622784
Rvn vn 0 1
Rab box b1 318.846342428262
Cab b1 0 2.08018025955902e-7
Rbl_b1 b1 0 1e+15
Ral box l1 330643.657098107
Vleak l1 0 0
Fpc1 0 prs Vcone1 -1
Fpc2 0 prs Vcone2 -1
Fpp 0 prs Vport 1
Fpl 0 prs Vleak 1
Lrad prs 0 0.191622551482642
Fx 0 xn Vcone1 18.8323917137476
Cx xn 0 1
Rbl_xn xn 0 1e+15
* probes: V(spk) V(prs) V(xn) V(vn) V(box) I(Vin) I(Vcone1) I(Vport) I(Vleak)
.model xf1 s_xfer(num_coeff=[1 0] den_coeff=[1 325.468998911903])
.model xf2 s_xfer(num_coeff=[1 0] den_coeff=[1 325.468998911903])
.ac dec 50 5 2000
.end
