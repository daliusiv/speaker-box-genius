* g-chain-015: chain (vented), rcf/l8s800 (Qts 0.41), 8.681 L, Fb 44.2 Hz, HP butterworth 3, 2 EQ, passive parts
* Speaker Box Genius SPICE validation netlist. SI units; acoustic side: Pa, m^3/s. See packages/engine/validation/spice/elements.ts.
V1 src 0 AC 15.6204993518133
A1 %vd(src 0) %vd(f1 0) xf1
A2 %vd(f1 0) %vd(f2 0) xf2
A3 %vd(f2 0) %vd(f3 0) xf3
A4 %vd(f3 0) %vd(amp 0) xf4
Rg amp spk 0.1
Vin spk n0 0
Rx1 n0 n1 2.425
Lx2 n1 0 0.004913
Lx3 n1 n3 0.006004
Vx9 n3 bk 0
Re1 bk c1a 6.1
Le1 c1a c1b 0.0009
Hemf1 c1b c1d Vcone1 476.178326650081
Vi1 c1d w1 0
Re2 w1 c2a 6.1
Le2 c2a c2b 0.0009
Hemf2 c2b c2d Vcone2 476.178326650081
Vi2 c2d w2 0
Re3 w2 c3a 6.1
Le3 c3a c3b 0.0009
Hemf3 c3b c3d Vcone3 476.178326650081
Vi3 c3d w3 0
Re4 w3 c4a 6.1
Le4 c4a c4b 0.0009
Hemf4 c4b c4d Vcone4 476.178326650081
Vi4 c4d 0 0
Hd1 u1h1 0 Vi1 476.178326650081
Ras11 u1h1 u1r1 4170.45451558515
Lmas11 u1r1 u1m1 45.3561441581783
Ccas11 u1m1 u1k1 1.55132087153554e-7
Rbl_u1k1 u1k1 0 1e+15
Vcone1 u1k1 box 0
Hd2 u2h1 0 Vi2 476.178326650081
Ras21 u2h1 u2r1 4170.45451558515
Lmas21 u2r1 u2m1 45.3561441581783
Ccas21 u2m1 u2k1 1.55132087153554e-7
Rbl_u2k1 u2k1 0 1e+15
Vcone2 u2k1 box 0
Hd3 u3h1 0 Vi3 476.178326650081
Ras31 u3h1 u3r1 4170.45451558515
Lmas31 u3r1 u3m1 45.3561441581783
Ccas31 u3m1 u3k1 1.55132087153554e-7
Rbl_u3k1 u3k1 0 1e+15
Vcone3 u3k1 box 0
Hd4 u4h1 0 Vi4 476.178326650081
Ras41 u4h1 u4r1 4170.45451558515
Lmas41 u4r1 u4m1 45.3561441581783
Ccas41 u4m1 u4k1 1.55132087153554e-7
Rbl_u4k1 u4k1 0 1e+15
Vcone4 u4k1 box 0
Rbl_box box 0 1e+15
Rap box p1 588.197409051554
Lmap p1 p2 211.784867343627
Vport p2 0 0
Fvp 0 vn Vport 193.076545389496
Rvn vn 0 1
Rab box b1 515.962639518907
Cab b1 0 6.1213711299091e-8
Rbl_b1 b1 0 1e+15
Ral box l1 941115.854482486
Vleak l1 0 0
Fpc1 0 prs Vcone1 -1
Fpc2 0 prs Vcone2 -1
Fpc3 0 prs Vcone3 -1
Fpc4 0 prs Vcone4 -1
Fpp 0 prs Vport 1
Fpl 0 prs Vleak 1
Lrad prs 0 0.191622551482642
Fx 0 xn Vcone1 50
Cx xn 0 1
Rbl_xn xn 0 1e+15
* probes: V(spk) V(prs) V(xn) V(vn) V(box) I(Vin) I(Vcone1) I(Vport) I(Vleak)
.model xf1 s_xfer(num_coeff=[1 0 0] den_coeff=[1 361.157491456683 130434.733635284])
.model xf2 s_xfer(num_coeff=[1 0] den_coeff=[1 361.157491456683])
.model xf3 s_xfer(num_coeff=[1.24824547392454 1812.93870452365 1862336.83524071] den_coeff=[1.24824547392454 1452.38956791383 1195248.57138953])
.model xf4 s_xfer(num_coeff=[1.18113625393405 561.233037321517 1336886.82513963] den_coeff=[1.18113625393405 475.163670111892 958284.896697835])
.ac dec 50 5 2000
.end
