* g-chain-033: chain (vented), redcatt/61xr (Qts 0.72), 7.543 L, Fb 56.7 Hz, HP butterworth 4, 3 EQ, passive parts
* Speaker Box Genius SPICE validation netlist. SI units; acoustic side: Pa, m^3/s. See packages/engine/validation/spice/elements.ts.
V1 src 0 AC 1.7606816861659
A1 %vd(src 0) %vd(f1 0) xf1
A2 %vd(f1 0) %vd(f2 0) xf2
A3 %vd(f2 0) %vd(f3 0) xf3
A4 %vd(f3 0) %vd(f4 0) xf4
A5 %vd(f4 0) %vd(amp 0) xf5
Rg amp spk 0.1
Vin spk n0 0
Vx1 n0 n1 0
Lx3 n1 n3 0.006613
Lx4 n3 x4n1 0.0009867
Cx4 x4n1 0 0.0004624
Rbl_x4c x4n1 0 1e+15
Vx9 n3 bk 0
Re1 bk c1a 3.1
Le1 c1a c1b 0.00006
Hemf1 c1b c1d Vcone1 363.947221062049
Vi1 c1d 0 0
Hd1 u1h1 0 Vi1 363.947221062049
Ras11 u1h1 u1r1 14242.7505073966
Lmas11 u1r1 u1m1 102.006186591455
Ccas11 u1m1 u1k1 6.06252863839839e-8
Rbl_u1k1 u1k1 0 1e+15
Vcone1 u1k1 box 0
Rbl_box box 0 1e+15
Rap box p1 788.354232886385
Lmap p1 p2 148.351476349707
Vport p2 0 0
Fvp 0 vn Vport 270.716768366253
Rvn vn 0 1
Cab box 0 5.3174015720278e-8
Ral box l1 1214853.87287792
Vleak l1 0 0
Fpc1 0 prs Vcone1 -1
Fpp 0 prs Vport 1
Fpl 0 prs Vleak 1
Lrad prs 0 0.19113747540989
Fx 0 xn Vcone1 75.3579502637528
Cx xn 0 1
Rbl_xn xn 0 1e+15
* probes: V(spk) V(prs) V(xn) V(vn) V(box) I(Vin) I(Vcone1) I(Vport) I(Vleak)
.model xf1 s_xfer(num_coeff=[1 0 0] den_coeff=[1 216.065756829629 79695.2750621626])
.model xf2 s_xfer(num_coeff=[1 0 0] den_coeff=[1 521.628880502499 79695.2750621626])
.model xf3 s_xfer(num_coeff=[1.41905752168909 2878.29670012414 4682731.85154985] den_coeff=[1.41905752168909 2028.3157350085 2325408.68089057])
.model xf4 s_xfer(num_coeff=[1 466.583641748911 172750.548017543] den_coeff=[1 468.844316179297 88998.1865177502])
.model xf5 s_xfer(num_coeff=[1 572.517595485458 415579.827300846] den_coeff=[1 547.715729878526 104462.798592665])
.ac dec 50 5 2000
.end
