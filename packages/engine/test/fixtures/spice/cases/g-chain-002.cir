* g-chain-002: chain (vented), peerless/hds-p830860 (Qts 0.54), 3.513 L, Fb 86.2 Hz, 1 EQ, passive parts
* Speaker Box Genius SPICE validation netlist. SI units; acoustic side: Pa, m^3/s. See packages/engine/validation/spice/elements.ts.
V1 src 0 AC 1.22474487139159
A1 %vd(src 0) %vd(amp 0) xf1
Rg amp spk 0.1
Vin spk n0 0
Vx1 n0 n1 0
Rx2 n1 0 6.796
Rx3 n1 n3 5.447
Rx4 n3 0 5.313
Vx9 n3 bk 0
Re1 bk c1a 6
Le1 c1a c1b 0.000278
Hemf1 c1b c1d Vcone1 651.17400107544
Vi1 c1d 0 0
Re2 bk c2a 6
Le2 c2a c2b 0.000278
Hemf2 c2b c2d Vcone2 651.17400107544
Vi2 c2d 0 0
Re3 bk c3a 6
Le3 c3a c3b 0.000278
Hemf3 c3b c3d Vcone3 651.17400107544
Vi3 c3d 0 0
Re4 bk c4a 6
Le4 c4a c4b 0.000278
Hemf4 c4b c4d Vcone4 651.17400107544
Vi4 c4d 0 0
Hd1 u1h1 0 Vi1 651.17400107544
Ras11 u1h1 u1r1 24633.0124411484
Lmas11 u1r1 u1m1 113.257897805085
Ccas11 u1m1 u1k1 4.31426456593002e-8
Rbl_u1k1 u1k1 0 1e+15
Vcone1 u1k1 box 0
Hd2 u2h1 0 Vi2 651.17400107544
Ras21 u2h1 u2r1 24633.0124411484
Lmas21 u2r1 u2m1 113.257897805085
Ccas21 u2m1 u2k1 4.31426456593002e-8
Rbl_u2k1 u2k1 0 1e+15
Vcone2 u2k1 box 0
Hd3 u3h1 0 Vi3 651.17400107544
Ras31 u3h1 u3r1 24633.0124411484
Lmas31 u3r1 u3m1 113.257897805085
Ccas31 u3m1 u3k1 4.31426456593002e-8
Rbl_u3k1 u3k1 0 1e+15
Vcone3 u3k1 box 0
Hd4 u4h1 0 Vi4 651.17400107544
Ras41 u4h1 u4r1 24633.0124411484
Lmas41 u4r1 u4m1 113.257897805085
Ccas41 u4m1 u4k1 4.31426456593002e-8
Rbl_u4k1 u4k1 0 1e+15
Vcone4 u4k1 box 0
Rbl_box box 0 1e+15
Rap box p1 1490.4690559633
Lmap p1 p2 137.536965525232
Vport p2 0 0
Fvp 0 vn Vport 657.366217317821
Rvn vn 0 1
Rab box b1 1520.88679179929
Cab b1 0 2.47647245426669e-8
Rbl_b1 b1 0 1e+15
Ral box l1 1117851.79197248
Vleak l1 0 0
Fpc1 0 prs Vcone1 -1
Fpc2 0 prs Vcone2 -1
Fpc3 0 prs Vcone3 -1
Fpc4 0 prs Vcone4 -1
Fpp 0 prs Vport 1
Fpl 0 prs Vleak 1
Lrad prs 0 0.19113747540989
Fx 0 xn Vcone1 113.250283125708
Cx xn 0 1
Rbl_xn xn 0 1e+15
* probes: V(spk) V(prs) V(xn) V(vn) V(box) I(Vin) I(Vcone1) I(Vport) I(Vleak)
.model xf1 s_xfer(num_coeff=[1 195.379489233607 312427.52267624] den_coeff=[1 222.141126518417 312427.52267624])
.ac dec 50 5 2000
.end
