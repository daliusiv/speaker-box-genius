* g-chain-003: chain (sealed), faital-pro/10fe200 (Qts 0.69), 29.99 L, HP linkwitz-riley 2, 2 EQ, passive parts
* Speaker Box Genius SPICE validation netlist. SI units; acoustic side: Pa, m^3/s. See packages/engine/validation/spice/elements.ts.
V1 src 0 AC 24.2899156029822
A1 %vd(src 0) %vd(f1 0) xf1
A2 %vd(f1 0) %vd(f2 0) xf2
A3 %vd(f2 0) %vd(f3 0) xf3
A4 %vd(f3 0) %vd(amp 0) xf4
Vrg amp spk 0
Vin spk n0 0
Vx1 n0 n1 0
Rx2 n1 x2n1 8.746
Lx2 x2n1 0 0.0004466
Rx3 n1 x3n1 11.54
Cx3 x3n1 n3 0.0003839
Rbl_x3c x3n1 n3 1e+15
Rx4 n3 0 1.072
Cx4 n3 0 0.00008563
Vx9 n3 bk 0
Re1 bk c1a 5.9
Le1 c1a c1b 0.00042
Hemf1 c1b c1d Vcone1 208.982482393818
Vi1 c1d 0 0
Hd1 u1h1 0 Vi1 208.982482393818
Ras11 u1h1 u1r1 484.753587537679
Lmas11 u1r1 u1m1 15.851009180202
Ccas11 u1m1 u1k1 5.28272455431279e-7
Rbl_u1k1 u1k1 0 1e+15
Vcone1 u1k1 box 0
Rbl_box box 0 1e+15
Cab box 0 2.56772948758251e-7
Fpc1 0 prs Vcone1 -1
Lrad prs 0 0.154384363389331
Fx 0 xn Vcone1 27.8009452321379
Cx xn 0 1
Rbl_xn xn 0 1e+15
* probes: V(spk) V(prs) V(xn) V(box) I(Vin) I(Vcone1)
.model xf1 s_xfer(num_coeff=[1 0] den_coeff=[1 203.63803580569])
.model xf2 s_xfer(num_coeff=[1 0] den_coeff=[1 203.63803580569])
.model xf3 s_xfer(num_coeff=[1 452.34503079006 933839.860517217] den_coeff=[1 522.359892420159 933839.860517217])
.model xf4 s_xfer(num_coeff=[1 925.128210642922 280220.275556829] den_coeff=[1 503.384527601419 81838.0056560567])
.ac dec 50 5 2000
.end
