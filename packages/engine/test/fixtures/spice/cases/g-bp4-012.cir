* g-bp4-012: bp4, celestion/tf0512he (Qts 0.54), 3.298 L, rear 1.455 L closed, front 1.843 L 2 × sb-acoustics/sb16pfc-00 at 125.2 Hz
* Speaker Box Genius SPICE validation netlist. SI units; acoustic side: Pa, m^3/s. See packages/engine/validation/spice/elements.ts.
V1 amp 0 AC 1.34412301024373
Rg amp spk 0.1
Vin spk bk 0
Re1 bk c1a 6.8258396
Le1 c1a c1b 0.00028
Hemf1 c1b c1d Vcone1 856.513759242739
Vi1 c1d 0 0
Re2 bk c2a 6.8258396
Le2 c2a c2b 0.00028
Hemf2 c2b c2d Vcone2 856.513759242739
Vi2 c2d 0 0
Re3 bk c3a 6.8258396
Le3 c3a c3b 0.00028
Hemf3 c3b c3d Vcone3 856.513759242739
Vi3 c3d 0 0
Hd1 u1h1 br Vi1 856.513759242739
Ras11 u1h1 u1r1 8348.63151532197
Lmas11 u1r1 u1m1 144.716612839818
Ccas11 u1m1 u1k1 2.43980464341499e-8
Rbl_u1k1 u1k1 0 1e+15
Vcone1 u1k1 bf 0
Hd2 u2h1 br Vi2 856.513759242739
Ras21 u2h1 u2r1 8348.63151532197
Lmas21 u2r1 u2m1 144.716612839818
Ccas21 u2m1 u2k1 2.43980464341499e-8
Rbl_u2k1 u2k1 0 1e+15
Vcone2 u2k1 bf 0
Hd3 u3h1 br Vi3 856.513759242739
Ras31 u3h1 u3r1 8348.63151532197
Lmas31 u3r1 u3m1 144.716612839818
Ccas31 u3m1 u3k1 2.43980464341499e-8
Rbl_u3k1 u3k1 0 1e+15
Vcone3 u3k1 bf 0
Rbl_bf bf 0 1e+15
Rabf bf fb1 978.390251446171
Cabf fb1 0 1.29958380283636e-8
Rbl_fb1 fb1 0 1e+15
Ralf bf fl1 978390.251446171
Vleakf fl1 0 0
Rpr1 bf r1 3850.3635554504
Lpr1 r1 q1 128.157518210198
Cpr1 q1 s1 4.30528e-7
Vpr1 s1 0 0
Fxp1 0 xp1 Vpr1 40.3225806451613
Cxp1 xp1 0 1
Rbl_xp1 xp1 0 1e+15
Rbl_br br 0 1e+15
Rabr br rb1 642.158356986239
Cabr rb1 0 1.02598721276555e-8
Rbl_rb1 rb1 0 1e+15
Ralr br rl1 642158.356986239
Vleakr rl1 0 0
Ricl br bf 15095160.6428537
Fpo1 0 prs Vleakf 1
Fpo2 0 prs Vpr1 1
Fpo3 0 prs Vleakr 1
Lrad prs 0 0.095811275741321
Fx 0 xn Vcone1 127.323656735421
Cx xn 0 1
Rbl_xn xn 0 1e+15
* probes: V(spk) V(prs) V(xn) V(br) V(bf) V(xp1) I(Vin) I(Vcone1) I(Vpr1)
.ac dec 50 5 2000
.end
