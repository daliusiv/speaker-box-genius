* g-chain-057: chain (vented), monacor/sp-90 (Qts 0.57), 23.54 L, Fb 36.2 Hz, HP butterworth 3, 1 EQ
* Speaker Box Genius SPICE validation netlist. SI units; acoustic side: Pa, m^3/s. See packages/engine/validation/spice/elements.ts.
V1 src 0 AC 4.41588043316392
A1 %vd(src 0) %vd(f1 0) xf1
A2 %vd(f1 0) %vd(f2 0) xf2
A3 %vd(f2 0) %vd(amp 0) xf3
Rg amp spk 0.5
Vin spk bk 0
Re1 bk c1a 6.5
Le1 c1a c1b 0.0005
Hemf1 c1b c1d Vcone1 337.863991393123
Vi1 c1d w1 0
Re2 w1 c2a 6.5
Le2 c2a c2b 0.0005
Hemf2 c2b c2d Vcone2 337.863991393123
Vi2 c2d w2 0
Re3 w2 c3a 6.5
Le3 c3a c3b 0.0005
Hemf3 c3b c3d Vcone3 337.863991393123
Vi3 c3d 0 0
Hd1 u1h1 0 Vi1 337.863991393123
Ras11 u1h1 u1r1 3554.18553765855
Lmas11 u1r1 u1m1 42.2364093748115
Ccas11 u1m1 u1k1 2.96161257293149e-7
Rbl_u1k1 u1k1 0 1e+15
Vcone1 u1k1 box 0
Hd2 u2h1 0 Vi2 337.863991393123
Ras21 u2h1 u2r1 3554.18553765855
Lmas21 u2r1 u2m1 42.2364093748115
Ccas21 u2m1 u2k1 2.96161257293149e-7
Rbl_u2k1 u2k1 0 1e+15
Vcone2 u2k1 box 0
Hd3 u3h1 0 Vi3 337.863991393123
Ras31 u3h1 u3r1 3554.18553765855
Lmas31 u3r1 u3m1 42.2364093748115
Ccas31 u3m1 u3k1 2.96161257293149e-7
Rbl_u3k1 u3k1 0 1e+15
Vcone3 u3k1 box 0
Rbl_box box 0 1e+15
Rap box p1 265.047218737517
Lmap p1 p2 116.608958355126
Vport p2 0 0
Fvp 0 vn Vport 225.571039522472
Rvn vn 0 1
Rab box b1 265.047218737517
Cab b1 0 1.65991333254303e-7
Rbl_b1 b1 0 1e+15
Ral box l1 265047.218737517
Vleak l1 0 0
Fpc1 0 prs Vcone1 -1
Fpc2 0 prs Vcone2 -1
Fpc3 0 prs Vcone3 -1
Fpp 0 prs Vport 1
Fpl 0 prs Vleak 1
Lrad prs 0 0.095811275741321
Fx 0 xn Vcone1 47.6190476190476
Cx xn 0 1
Rbl_xn xn 0 1e+15
* probes: V(spk) V(prs) V(xn) V(vn) V(box) I(Vin) I(Vcone1) I(Vport) I(Vleak)
.model xf1 s_xfer(num_coeff=[1 0 0] den_coeff=[1 244.101749183927 59585.6639546528])
.model xf2 s_xfer(num_coeff=[1 0] den_coeff=[1 244.101749183927])
.model xf3 s_xfer(num_coeff=[0.920884154072904 479.049269974531 935006.449997409] den_coeff=[1 499.203570211252 935006.449997409])
.ac dec 50 5 2000
.end
