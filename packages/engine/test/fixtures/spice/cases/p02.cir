* p02: passive-radiator, bc-speakers/15sw115-8ohm (Qts 0.24), 58.53 L, Fb 26.9 Hz, 1 × dayton-audio/rss390-pr + 1 × sb-acoustics/sw26dbac-00, PR 25 cm from the cone (on axis)
* Speaker Box Genius SPICE validation netlist. SI units; acoustic side: Pa, m^3/s. See packages/engine/validation/spice/elements.ts.
V1 amp 0 AC 22.8035085019828
Vrg amp spk 0
Vin spk bk 0
Re1 bk c1a 5.2
Le1 c1a c1b 0.0018
Hemf1 c1b c1d Vcone1 349.247810880237
Vi1 c1d 0 0
Hd1 u1h1 0 Vi1 349.247810880237
Ras11 u1h1 u1r1 1332.75823213109
Lmas11 u1r1 u1m1 26.6658933313242
Ccas11 u1m1 u1k1 7.75439709562585e-7
Rbl_u1k1 u1k1 0 1e+15
Vcone1 u1k1 box 0
Rbl_box box 0 1e+15
Rpr1 box r1 1522.25272185762
Lpr1 r1 q1 107.710120898036
Cpr1 q1 s1 0.000001514119552
Vpr1 s1 0 0
Fxp1 0 xp1 Vpr1 12.0540019286403
Cxp1 xp1 0 1
Rbl_xp1 xp1 0 1e+15
Rpr2 box r2 3738.57271413019
Lpr2 r2 q2 410.913872452334
Cpr2 q2 s2 3.796416e-7
Vpr2 s2 0 0
Fxp2 0 xp2 Vpr2 32.0512820512821
Cxp2 xp2 0 1
Rbl_xp2 xp2 0 1e+15
Rab box b1 158.712776604966
Cab b1 0 4.12604420006346e-7
Rbl_b1 b1 0 1e+15
Ral box l1 158712.776604966
Vleak l1 0 0
Fpc1 0 prc Vcone1 -1
Fpl 0 prv Vleak 1
Fpr1 0 prv Vpr1 1
Fpr2 0 prv Vpr2 1
Lradc prc 0 0.19113747540989
Lradv prv 0 0.19113747540989
Ebuf pvb 0 prv 0 1
Tpos pvb 0 pvd 0 Z0=1 Td=0.000727412134433558
Rtpos pvd 0 1
Eprc prs pm prc 0 1
Eprv pm 0 pvd 0 1
Fx 0 xn Vcone1 11.6959064327485
Cx xn 0 1
Rbl_xn xn 0 1e+15
* probes: V(spk) V(prs) V(xn) V(box) V(xp1) V(xp2) I(Vin) I(Vcone1) I(Vleak) I(Vpr1) I(Vpr2)
.ac dec 50 5 2000
.end
