* g-chain-029: chain (sealed), celestion/truvox-1225 (Qts 0.62), 22 L, HP butterworth 3, 1 EQ, passive parts
* Speaker Box Genius SPICE validation netlist. SI units; acoustic side: Pa, m^3/s. See packages/engine/validation/spice/elements.ts.
V1 src 0 AC 2.52586618806302
A1 %vd(src 0) %vd(f1 0) xf1
A2 %vd(f1 0) %vd(f2 0) xf2
A3 %vd(f2 0) %vd(amp 0) xf3
Rg amp spk 0.1
Vin spk n0 0
Vx1 n0 n1 0
Rx3 n1 n3 7.599
Lx3 n1 n3 0.00269
Cx3 n1 n3 0.0008579
Vx9 n3 bk 0
Re1 bk c1a 6.38
Le1 c1a c1b 0.00068
Hemf1 c1b c1d Vcone1 254.513771586277
Vi1 c1d 0 0
Hd1 u1h1 0 Vi1 254.513771586277
Ras11 u1h1 u1r1 935.757550521717
Lmas11 u1r1 u1m1 18.2495359693432
Ccas11 u1m1 u1k1 3.81727820661945e-7
Rbl_u1k1 u1k1 0 1e+15
Vcone1 u1k1 box 0
Rbl_box box 0 1e+15
Rab box b1 443.582722577421
Cab b1 0 1.55087941912517e-7
Rbl_b1 b1 0 1e+15
Ral box l1 192096.949394465
Vleak l1 0 0
Fpc1 0 prs Vcone1 -1
Fpl 0 prs Vleak 1
Lrad prs 0 0.19113747540989
Fx 0 xn Vcone1 18.8348746539092
Cx xn 0 1
Rbl_xn xn 0 1e+15
* probes: V(spk) V(prs) V(xn) V(box) I(Vin) I(Vcone1) I(Vleak)
.model xf1 s_xfer(num_coeff=[1 0 0] den_coeff=[1 252.96104046705 63989.2879941726])
.model xf2 s_xfer(num_coeff=[1 0] den_coeff=[1 252.96104046705])
.model xf3 s_xfer(num_coeff=[1 639.508800579121 282419.772167397] den_coeff=[1 276.865980547222 48167.8107633228])
.ac dec 50 5 2000
.end
