* g-chain-045: chain (sealed), beyma/12cxa400nd (Qts 0.25), 74.83 L, 1 EQ, passive parts
* Speaker Box Genius SPICE validation netlist. SI units; acoustic side: Pa, m^3/s. See packages/engine/validation/spice/elements.ts.
V1 src 0 AC 25.6904651573303
A1 %vd(src 0) %vd(amp 0) xf1
Rg amp spk 0.1
Vin spk n0 0
Rx1 n0 n1 5.827
Cx1 n0 n1 0.0006011
Rx2 n1 0 7.912
Cx2 n1 0 0.0004866
Vx3 n1 n3 0
Cx4 n3 0 0.000671
Rbl_x4c n3 0 1e+15
Vx9 n3 bk 0
Re1 bk c1a 6.6
Le1 c1a c1b 0.001
Hemf1 c1b c1d Vcone1 344.216009874515
Vi1 c1d 0 0
Hd1 u1h1 0 Vi1 344.216009874515
Ras11 u1h1 u1r1 657.405291891214
Lmas11 u1r1 u1m1 16.5081787314828
Ccas11 u1m1 u1k1 7.57732776428982e-7
Rbl_u1k1 u1k1 0 1e+15
Vcone1 u1k1 box 0
Rbl_box box 0 1e+15
Rab box b1 68.9583168873322
Cab b1 0 6.40690888815602e-7
Rbl_b1 b1 0 1e+15
Ral box l1 37364.9118014382
Vleak l1 0 0
Fpc1 0 prs Vcone1 -1
Fpl 0 prs Vleak 1
Lrad prs 0 0.0385960908473327
Fx 0 xn Vcone1 18.1818181818182
Cx xn 0 1
Rbl_xn xn 0 1e+15
* probes: V(spk) V(prs) V(xn) V(box) I(Vin) I(Vcone1) I(Vleak)
.model xf1 s_xfer(num_coeff=[1 525.01664462313 106093.730980737] den_coeff=[1 377.358489031597 42653.9391333574])
.ac dec 50 5 2000
.end
