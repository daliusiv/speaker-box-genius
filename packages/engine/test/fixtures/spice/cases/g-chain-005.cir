* g-chain-005: chain (sealed), beyma/12lex1000fe (Qts 0.29), 29.82 L, 3 EQ, passive parts
* Speaker Box Genius SPICE validation netlist. SI units; acoustic side: Pa, m^3/s. See packages/engine/validation/spice/elements.ts.
V1 src 0 AC 2.83
A1 %vd(src 0) %vd(f1 0) xf1
A2 %vd(f1 0) %vd(f2 0) xf2
A3 %vd(f2 0) %vd(amp 0) xf3
Rg amp spk 0.1
Vin spk n0 0
Rx1 n0 n1 7.573
Lx1 n0 n1 0.002874
Cx2 n1 0 0.0000622
Rbl_x2c n1 0 1e+15
Vx3 n1 n3 0
Rx4 n3 0 2.418
Lx4 n3 0 0.001027
Vx9 n3 bk 0
Re1 bk c1a 5.4
Le1 c1a c1b 0.0017
Hemf1 c1b c1d Vcone1 449.91329520193
Vi1 c1d 0 0
Hd1 u1h1 0 Vi1 449.91329520193
Ras11 u1h1 u1r1 3332.04894155489
Lmas11 u1r1 u1m1 38.9617023432914
Ccas11 u1m1 u1k1 2.70776006668022e-7
Rbl_u1k1 u1k1 0 1e+15
Vcone1 u1k1 box 0
Rbl_box box 0 1e+15
Cab box 0 2.10274492678136e-7
Ral box l1 285952.205896753
Vleak l1 0 0
Fpc1 0 prs Vcone1 -1
Fpl 0 prs Vleak 1
Lrad prs 0 0.191622551482642
Fx 0 xn Vcone1 18.1818181818182
Cx xn 0 1
Rbl_xn xn 0 1e+15
* probes: V(spk) V(prs) V(xn) V(box) I(Vin) I(Vcone1) I(Vleak)
.model xf1 s_xfer(num_coeff=[1 90.8001276408593 140516.147642504] den_coeff=[1 124.261462005472 140516.147642504])
.model xf2 s_xfer(num_coeff=[1 398.929880670599 99725.1516096369] den_coeff=[1 329.830169057371 38306.7968659041])
.model xf3 s_xfer(num_coeff=[0.47103155278696 115.411784408463 203104.665504444] den_coeff=[1 168.160951407102 203104.665504444])
.ac dec 50 5 2000
.end
