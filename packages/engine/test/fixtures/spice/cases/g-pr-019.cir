* g-pr-019: passive-radiator, sb-acoustics/mr16tx-8 (Qts 0.30), 19.29 L, Fb 34.7 Hz, 4 × purifi/ptt6-5pr-na2-03
* Speaker Box Genius SPICE validation netlist. SI units; acoustic side: Pa, m^3/s. See packages/engine/validation/spice/elements.ts.
V1 amp 0 AC 17.606816861659
Rg amp spk 0.1
Vin spk bk 0
Re1 bk c1a 6.2
Le1 c1a c1b 0.00011
Hemf1 c1b c1d Vcone1 514.322705385854
Vi1 c1d 0 0
Re2 bk c2a 6.2
Le2 c2a c2b 0.00011
Hemf2 c2b c2d Vcone1 514.322705385854
Vi2 c2d 0 0
Hd1 u1h1 0 Vi1 514.322705385854
Hd2 u1h2 u1h1 Vi2 514.322705385854
Ras11 u1h2 u1r1 2110.20866750101
Lmas11 u1r1 u1m1 62.0842973803234
Ccas11 u1m1 u1k1 3.33059943537711e-7
Rbl_u1k1 u1k1 0 1e+15
Ras12 u1k1 u1r2 2110.20866750101
Lmas12 u1r2 u1m2 62.0842973803234
Ccas12 u1m2 u1k2 3.33059943537711e-7
Rbl_u1k2 u1k2 0 1e+15
Vcone1 u1k2 box 0
Rbl_box box 0 1e+15
Rpr1 box r1 1103.39091543381
Lpr1 r1 q1 164.231493717237
Cpr1 q1 s1 5.77584712e-7
Vpr1 s1 0 0
Fxp1 0 xp1 Vpr1 18.8394875659382
Cxp1 xp1 0 1
Rbl_xp1 xp1 0 1e+15
Rab box b1 357.591892045308
Cab b1 0 1.6516005940469e-7
Rbl_b1 b1 0 1e+15
Ral box l1 357591.892045308
Vleak l1 0 0
Fpc1 0 prs Vcone1 -1
Fpl 0 prs Vleak 1
Fpr1 0 prs Vpr1 1
Lrad prs 0 0.154384363389331
Fx 0 xn Vcone1 85.4700854700855
Cx xn 0 1
Rbl_xn xn 0 1e+15
* probes: V(spk) V(prs) V(xn) V(box) V(xp1) I(Vin) I(Vcone1) I(Vleak) I(Vpr1)
.ac dec 50 5 2000
.end
