* g-bp6s-004: bp6s, celestion/truvox-1525 (Qts 0.76), 112.9 L, rear 34.4 L port at 46.4 Hz, front 78.48 L port at 68.2 Hz
* Speaker Box Genius SPICE validation netlist. SI units; acoustic side: Pa, m^3/s. See packages/engine/validation/spice/elements.ts.
V1 amp 0 AC 2.8831544877096
Vrg amp spk 0
Vin spk bk 0
Re1 bk c1a 8.3125798
Le1 c1a c1b 0.000703
Hemf1 c1b c1d Vcone1 166.962289115175
Vi1 c1d m1 0
Re2 m1 c2a 8.3125798
Le2 c2a c2b 0.000703
Hemf2 c2b c2d Vcone1 166.962289115175
Vi2 c2d 0 0
Hd1 u1h1 br Vi1 166.962289115175
Hd2 u1h2 u1h1 Vi2 166.962289115175
Ras11 u1h2 u1r1 263.348683927084
Lmas11 u1r1 u1m1 11.0496999260147
Ccas11 u1m1 u1k1 9.54767481845056e-7
Rbl_u1k1 u1k1 0 1e+15
Ras12 u1k1 u1r2 263.348683927084
Lmas12 u1r2 u1m2 11.0496999260147
Ccas12 u1m2 u1k2 9.54767481845056e-7
Rbl_u1k2 u1k2 0 1e+15
Vcone1 u1k2 bf 0
Rbl_bf bf 0 1e+15
Rabf bf fb1 42.1878110716526
Cabf fb1 0 5.53398463627769e-7
Rbl_fb1 fb1 0 1e+15
Ralf bf fl1 42187.8110716526
Vleakf fl1 0 0
Rapf bf fp1 34.8659595633492
Lmapf fp1 fp2 9.84944895977042
Vportf fp2 0 0
Fvf 0 vf Vportf 44.8257321218731
Rvf vf 0 1
Rbl_br br 0 1e+15
Rabr br rb1 141.509427347146
Cabr rb1 0 2.42570172640103e-7
Rbl_rb1 rb1 0 1e+15
Ralr br rl1 141509.427347146
Vleakr rl1 0 0
Rapr br rp1 112.309069323132
Lmapr rp1 rp2 48.5744782318428
Vportr rp2 bf 0
Fvr 0 vr Vportr 54.5619937738218
Rvr vr 0 1
Ricl br bf 326586.076701127
Fpo1 0 prs Vleakf 1
Fpo2 0 prs Vportf 1
Fpo3 0 prs Vleakr 1
Lrad prs 0 0.191622551482642
Fx 0 xn Vcone1 11.6918040453642
Cx xn 0 1
Rbl_xn xn 0 1e+15
* probes: V(spk) V(prs) V(xn) V(vf) V(vr) V(br) V(bf) I(Vin) I(Vcone1) I(Vportf)
.ac dec 50 5 2000
.end
