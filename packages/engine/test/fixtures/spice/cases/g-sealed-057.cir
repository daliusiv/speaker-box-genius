* g-sealed-057: sealed, bc-speakers/15sw115-4ohm (Qts 0.22), 144.8 L
* Speaker Box Genius SPICE validation netlist. SI units; acoustic side: Pa, m^3/s. See packages/engine/validation/spice/elements.ts.
V1 amp 0 AC 1.78885438199983
Vrg amp spk 0
Vin spk bk 0
Re1 bk c1a 3.652736
Le1 c1a c1b 0.00127
Hemf1 c1b c1d Vcone1 296.626093995001
Vi1 c1d 0 0
Hd1 u1h1 0 Vi1 296.626093995001
Ras11 u1h1 u1r1 1090.35663345411
Lmas11 u1r1 u1m1 29.6031399439441
Ccas11 u1m1 u1k1 7.40192450037013e-7
Rbl_u1k1 u1k1 0 1e+15
Vcone1 u1k1 box 0
Rbl_box box 0 1e+15
Rab box b1 437.174577260981
Cab b1 0 0.00000102076063586057
Rbl_b1 b1 0 1e+15
Ral box l1 48880.2479699728
Vleak l1 0 0
Fpc1 0 prs Vcone1 -1
Fpl 0 prs Vleak 1
Lrad prs 0 0.095568737704945
Fx 0 xn Vcone1 11.6959064327485
Cx xn 0 1
Rbl_xn xn 0 1e+15
* probes: V(spk) V(prs) V(xn) V(box) I(Vin) I(Vcone1) I(Vleak)
.ac dec 50 5 2000
.end
